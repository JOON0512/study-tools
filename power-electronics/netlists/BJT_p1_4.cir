Hart P1-4: base drive referred to emitter; RB=100 ohm
VS VP 0 24
ILOAD OUT 0 2
Q1 VP BASE OUT QMOD
VB DRIVE OUT PULSE(0 5 0 1n 1n 2.5u 5u)
RB DRIVE BASE 100
D1 0 OUT DMOD
.MODEL QMOD NPN(BF=100)
.MODEL DMOD D(IS=1e-14 N=1)
.TRAN 5n 50u
.PROBE V(OUT) I(VS)
.END
