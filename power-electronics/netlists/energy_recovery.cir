P2-36: two-switch energy recovery; each switch 1 ohm
VS VP 0 75
S1 VP N1 CTRL 0 SWMOD
RW N1 N2 20
L1 N2 N3 100m
S2 N3 0 CTRL 0 SWMOD
DRETURN N3 VP DMOD
DFREE 0 N1 DMOD
VCTRL CTRL 0 PULSE(0 5 0 10n 10n 40m 100m)
.MODEL SWMOD VSWITCH(RON=1 ROFF=1e10 VON=1 VOFF=0)
.MODEL DMOD D(IS=1e-14 N=1)
.TRAN 2u 1 0.8 2u
.PROBE I(VS) I(L1) I(DRETURN) I(DFREE)
.END
