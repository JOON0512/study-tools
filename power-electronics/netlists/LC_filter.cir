Full-wave LC filter. Rload=5 or 50; winding resistance=0.5 for P4-22
.PARAM VM=100 FREQ=60 RLOAD=50 RCOIL=0.5 NVAL=0.001
VS AC 0 SIN(0 {VM} {FREQ})
D1 AC P DMOD
D2 0 P DMOD
D3 M AC DMOD
D4 M 0 DMOD
RW P N1 {RCOIL}
L1 N1 OUT 5m
C1 OUT M 10000u
R1 OUT M {RLOAD}
RREF M 0 1e10
.MODEL DMOD D(IS=1e-14 N={NVAL})
.TRAN 5u 10 9.9 5u
.PROBE V(OUT,M) I(L1) I(D1)
.END
