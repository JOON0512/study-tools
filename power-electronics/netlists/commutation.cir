Half-wave freewheel with source inductance, P3-38 defaults
.PARAM LSRC=10m RLOAD=20 LLOAD=500m NVAL=1
VS AC 0 SIN(0 169.705627 60)
LS AC AN {LSRC}
D1 AN OUT DMOD
D2 0 OUT DMOD
R1 OUT LN {RLOAD}
L1 LN 0 {LLOAD}
.MODEL DMOD D(IS=1e-14 N={NVAL})
.TRAN 1u 2 1.9 1u
.PROBE V(OUT) I(D1) I(D2) I(L1)
.END
