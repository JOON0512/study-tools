Inductor charge and resistor discharge: P2-35
.PARAM VCC=90 LVAL=100m RDIS=20 RONVAL=0.001 NVAL=0.001 TON=4m TPER=40m
VS VP 0 {VCC}
L1 VP SW {LVAL}
S1 SW 0 CTRL 0 SWMOD
D1 SW ND DMOD
R1 ND VP {RDIS}
VCTRL CTRL 0 PULSE(0 5 0 10n 10n {TON} {TPER})
.MODEL SWMOD VSWITCH(RON={RONVAL} ROFF=1e10 VON=1 VOFF=0)
.MODEL DMOD D(IS=1e-14 N={NVAL})
.TRAN 2u 800m 720m 2u
.PROBE I(L1) I(D1) I(VS)
.END
