HW1-1 and Hart P1-2: source to constant-current load
* PSpice syntax. Not executed in this environment.
.PARAM RONVAL=0.001 NVAL=0.001 DUTY=0.5 FS=200k
VS VIN 0 DC 24
ILOAD OUT 0 DC 2
S1 VIN OUT CTRL 0 SWMOD
DFREE 0 OUT DMOD
VCTRL CTRL 0 PULSE(0 5 0 1n 1n {DUTY/FS} {1/FS})
.MODEL SWMOD VSWITCH(RON={RONVAL} ROFF=1e9 VON=1 VOFF=0)
.MODEL DMOD D(IS=1e-14 N={NVAL})
.TRAN 5n 50u
.PROBE V(OUT) I(VS) I(DFREE)
.END
