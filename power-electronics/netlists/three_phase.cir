Six-pulse bridge, 4-51 secondary-side design (no explicit transformer)
.PARAM VLL=222.144147 RLOAD=20 LLOAD=15m NVAL=0.001
VA A 0 SIN(0 {VLL*SQRT(2/3)} 60 0 0 0)
VB B 0 SIN(0 {VLL*SQRT(2/3)} 60 0 0 -120)
VC C 0 SIN(0 {VLL*SQRT(2/3)} 60 0 0 120)
D1 A P DMOD
D2 B P DMOD
D3 C P DMOD
D4 M A DMOD
D5 M B DMOD
D6 M C DMOD
R1 P LN {RLOAD}
L1 LN M {LLOAD}
RREF M 0 1e10
.MODEL DMOD D(IS=1e-14 N={NVAL})
.TRAN 1u 500m 450m 1u
.PROBE V(P,M) I(L1) I(VA) I(D1)
.END
