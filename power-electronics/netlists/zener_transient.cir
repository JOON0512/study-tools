P2-37 part b defaults; part a: RCOIL=1n (near-zero), RONVAL=0.001
.PARAM VCC=12 LVAL=75m VZ=20 RCOIL=1.5 RONVAL=0.5 TON=20m TPER=70m
VS IN 0 DC {VCC}
RL IN LN {RCOIL}
L1 LN SW {LVAL}
S1 SW 0 CTRL 0 SWMOD
DZ 0 SW ZMOD
VCTRL CTRL 0 PULSE(0 5 0 10n 10n {TON} {TPER})
.MODEL SWMOD VSWITCH(RON={RONVAL} ROFF=1e10 VON=1 VOFF=0)
.MODEL ZMOD D(N=0.001 BV={VZ} IBV=10)
.TRAN 10u 700m 560m 10u
.PROBE I(L1) I(DZ) V(SW)
.END
