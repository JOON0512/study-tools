Single-phase full-wave capacitor-input filter
.PARAM VM=169.705627 FREQ=60 RLOAD=500 CVAL=1666.6667u NVAL=0.001
VS AC 0 SIN(0 {VM} {FREQ})
D1 AC P DMOD
D2 0 P DMOD
D3 M AC DMOD
D4 M 0 DMOD
C1 P M {CVAL}
R1 P M {RLOAD}
RREF M 0 1e10
.MODEL DMOD D(IS=1e-14 N={NVAL})
.TRAN 1u 2 1.95 1u
.PROBE V(P,M) I(D1) I(VS)
.END
