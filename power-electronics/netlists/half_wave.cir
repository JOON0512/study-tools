Half-wave RLE: change parameters for each exercise
.PARAM VM=169.705627 RLOAD=2 LLOAD=20m ELOAD=100 FREQ=60 NVAL=0.001
VS AC 0 SIN(0 {VM} {FREQ})
D1 AC N1 DMOD
R1 N1 N2 {RLOAD}
L1 N2 N3 {LLOAD}
VBAT N3 0 DC {ELOAD}
.MODEL DMOD D(IS=1e-14 N={NVAL})
.TRAN 2u 500m 450m 2u
.PROBE V(AC) I(L1) I(VS) I(VBAT)
.END
