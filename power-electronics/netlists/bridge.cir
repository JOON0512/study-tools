Full-wave bridge RLE
.PARAM VM=169.705627 FREQ=60 RLOAD=2 LLOAD=10m ELOAD=80 NVAL=0.001
VS AC 0 SIN(0 {VM} {FREQ})
D1 AC P DMOD
D2 0 P DMOD
D3 M AC DMOD
D4 M 0 DMOD
R1 P N1 {RLOAD}
L1 N1 N2 {LLOAD}
VBAT N2 M DC {ELOAD}
RREF M 0 1e10
.MODEL DMOD D(IS=1e-14 N={NVAL})
.TRAN 2u 500m 450m 2u
.PROBE V(P,M) I(L1) I(VS) I(D1)
.END
